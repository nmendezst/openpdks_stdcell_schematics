.SUBCKT AND3X1H7R A B C VDD VSS Y
*.PININFO A:I B:I C:I Y:O VDD:B VSS:B
MMN3 net10 B net7 VSS nm1p2_svt_lp W=150n L=60n m=1
MMN4 net7 A VSS VSS nm1p2_svt_lp W=150n L=60n m=1
MMN0 net36 C net10 VSS nm1p2_svt_lp W=150n L=60n m=1
MMP2 net36 C VDD VDD pm1p2_svt_lp W=150n L=60n m=1
MMP1 net36 B VDD VDD pm1p2_svt_lp W=150n L=60n m=1
MMP0 net36 A VDD VDD pm1p2_svt_lp W=150n L=60n m=1
XI1 net36 VDD VSS Y / INV pl=6e-08 pw=2.7e-07 nl=6e-08 nw=2.1e-07
.ENDS
