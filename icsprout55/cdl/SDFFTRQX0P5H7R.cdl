.SUBCKT SDFFTRQX0P5H7R CK D Q RN SE SI VDD VSS
*.PININFO CK:I D:I RN:I SE:I SI:I Q:O VDD:B VSS:B
XXI20 sen SE net034 net046 VDD VSS / TG pl=60n pw=280n nl=60n nw=240n
XXI21 c cn net46 net25 VDD VSS / TG pl=60n pw=280n nl=60n nw=200n
XXI17 D RN VDD VSS net034 / NAND2 pl=60n pw=280n nl=60n nw=240n
XXI15 net9 cn c VDD VSS net25 / TSINV pl=60n pw=150n nl=60n nw=150n
XXI19 net046 cn c VDD VSS net33 / TSINV pl=60n pw=280n nl=60n nw=200n
XXI22 SI SE sen VDD VSS net046 / TSINV pl=60n pw=280n nl=60n nw=200n
XXI14 net46 c cn VDD VSS net33 / TSINV pl=60n pw=150n nl=60n nw=150n
XXI4 CK VDD VSS cn / INV pl=60n pw=280n nl=60n nw=200n
XXI10 net25 VDD VSS net9 / INV pl=60n pw=280n nl=60n nw=200n
XXI12 net25 VDD VSS Q / INV pl=60n pw=280n nl=60n nw=200n
XXI13 cn VDD VSS c / INV pl=60n pw=280n nl=60n nw=200n
XXI7 net33 VDD VSS net46 / INV pl=60n pw=280n nl=60n nw=200n
XXI23 SE VDD VSS sen / INV pl=60n pw=280n nl=60n nw=200n
.ENDS
