.SUBCKT FILLER16H7R VDD VSS
*.PININFO VDD:B VSS:B
.ENDS
