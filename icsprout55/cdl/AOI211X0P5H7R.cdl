.SUBCKT AOI211X0P5H7R A0 A1 B0 C0 VDD VSS Y
*.PININFO A0:I A1:I B0:I C0:I Y:O VDD:B VSS:B
MMN5 Y B0 VSS VSS nm1p2_svt_lp W=150n L=60n m=1
MMN4 net13 A0 VSS VSS nm1p2_svt_lp W=150n L=60n m=1
MMN1 Y A1 net13 VSS nm1p2_svt_lp W=150n L=60n m=1
MMN0 Y C0 VSS VSS nm1p2_svt_lp W=150n L=60n m=1
MMP3 Y B0 net8 VDD pm1p2_svt_lp W=190n L=60n m=1
MMP2 net8 C0 net039 VDD pm1p2_svt_lp W=190n L=60n m=1
MMP1 net039 A1 VDD VDD pm1p2_svt_lp W=190n L=60n m=1
MMP0 net039 A0 VDD VDD pm1p2_svt_lp W=190n L=60n m=1
.ENDS
