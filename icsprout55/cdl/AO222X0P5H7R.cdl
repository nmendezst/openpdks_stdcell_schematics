.SUBCKT AO222X0P5H7R A0 A1 B0 B1 C0 C1 VDD VSS Y
*.PININFO A0:I A1:I B0:I B1:I C0:I C1:I Y:O VDD:B VSS:B
MMNM5 net17 A0 VSS VSS nm1p2_svt_lp W=150n L=60n m=1
MMNM4 net44 A1 net17 VSS nm1p2_svt_lp W=150n L=60n m=1
MMNM3 net32 B0 VSS VSS nm1p2_svt_lp W=150n L=60n m=1
MMNM2 net44 B1 net32 VSS nm1p2_svt_lp W=150n L=60n m=1
MMNM1 net48 C0 VSS VSS nm1p2_svt_lp W=150n L=60n m=1
MMNM0 net44 C1 net48 VSS nm1p2_svt_lp W=150n L=60n m=1
MMPM5 net44 C1 net19 VDD pm1p2_svt_lp W=190n L=60n m=1
MMPM4 net44 C0 net19 VDD pm1p2_svt_lp W=190n L=60n m=1
MMPM3 net19 B1 net15 VDD pm1p2_svt_lp W=190n L=60n m=1
MMPM2 net19 B0 net15 VDD pm1p2_svt_lp W=190n L=60n m=1
MMPM1 net15 A1 VDD VDD pm1p2_svt_lp W=190n L=60n m=1
MMPM0 net15 A0 VDD VDD pm1p2_svt_lp W=190n L=60n m=1
XXI1 net44 VDD VSS Y / INV pl=60n pw=190n nl=60n nw=150n
.ENDS
