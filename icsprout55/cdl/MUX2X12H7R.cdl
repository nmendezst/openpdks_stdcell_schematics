.SUBCKT MUX2X12H7R A B S0 VDD VSS Y
*.PININFO A:I B:I S0:I Y:O VDD:B VSS:B
XXI9 B VDD VSS BN / INV pl=60n pw=930n nl=60n nw=750n
XXI7 A VDD VSS AN / INV pl=60n pw=930n nl=60n nw=750n
XXI0 S0 VDD VSS S0N / INV pl=60n pw=380n nl=60n nw=300n
XXI2 net19 VDD VSS Y / INV pl=60n pw=2.28u nl=60n nw=1.8u
XXI8 S0 S0N BN net19 VDD VSS / TG pl=60n pw=930n nl=60n nw=750n
XXI6 S0N S0 AN net19 VDD VSS / TG pl=60n pw=930n nl=60n nw=750n
.ENDS
