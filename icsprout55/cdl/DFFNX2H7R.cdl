.SUBCKT DFFNX2H7R CKN D Q QN VDD VSS
*.PININFO CKN:I D:I Q:O QN:O VDD:B VSS:B
XI9 D CKB CKP VDD VSS net68 / TSINV pl=6E-08 pw=2.8E-07 nl=6E-08 nw=2E-07
XI3 net61 CKB CKP VDD VSS net64 / TSINV pl=6E-08 pw=1.5E-07 nl=6E-08 nw=1.5E-07
XXI29 net73 CKP CKB VDD VSS net68 / TSINV pl=6E-08 pw=1.5E-07 nl=6E-08 nw=1.5E-07
XI4 net73 CKP CKB VDD VSS net64 / TSINV pl=6E-08 pw=3.4E-07 nl=6E-08 nw=2.4E-07
XI12 net64 VDD VSS Q / INV pl=6E-08 pw=4E-07 nl=6E-08 nw=2.8E-07
XI11 net64 VDD VSS net61 / INV pl=6E-08 pw=3.4E-07 nl=6E-08 nw=2.4E-07
XI6 net61 VDD VSS QN / INV pl=6E-08 pw=4E-07 nl=6E-08 nw=2.8E-07
XI8 CKP VDD VSS CKB / INV pl=6E-08 pw=3.4E-07 nl=6E-08 nw=2.4E-07
XI10 net68 VDD VSS net73 / INV pl=6E-08 pw=3.4E-07 nl=6E-08 nw=2.4E-07
XI0 CKN VDD VSS CKP / INV pl=6E-08 pw=3.4E-07 nl=6E-08 nw=2.4E-07
.ENDS
