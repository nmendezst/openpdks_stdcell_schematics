.SUBCKT OAO211X3H7R A0 A1 B0 C0 VDD VSS Y
*.PININFO A0:I A1:I B0:I C0:I Y:O VDD:B VSS:B
MMM6 net26 C0 net14 VDD pm1p2_svt_lp W=270n L=60n m=1
MMM5 net14 A0 net17 VDD pm1p2_svt_lp W=270n L=60n m=1
MMM0 net17 A1 VDD VDD pm1p2_svt_lp W=270n L=60n m=1
MMM4 net14 B0 VDD VDD pm1p2_svt_lp W=270n L=60n m=1
MMM7 net26 C0 VSS VSS nm1p2_svt_lp W=210n L=60n m=1
MMM3 net34 A0 VSS VSS nm1p2_svt_lp W=210n L=60n m=1
MMM2 net34 A1 VSS VSS nm1p2_svt_lp W=210n L=60n m=1
MMM8 net26 B0 net34 VSS nm1p2_svt_lp W=210n L=60n m=1
XXI3 net26 VDD VSS Y / INV pl=6e-08 pw=5.7e-07 nl=6e-08 nw=4.5e-07
.ENDS
