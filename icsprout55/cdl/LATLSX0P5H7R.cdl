.SUBCKT LATLSX0P5H7R D GN Q QN SN VDD VSS
*.PININFO D:I GN:I SN:I Q:O QN:O VDD:B VSS:B
MNM1 net44 D VSS VSS nm1p2_svt_lp W=200n L=60n m=1
MNM2 netq S VSS VSS nm1p2_svt_lp W=200n L=60n m=1
MNM0 netq GB net38 VSS nm1p2_svt_lp W=150n L=60n m=1
MMN4 net38 netqn VSS VSS nm1p2_svt_lp W=150n L=60n m=1
MPM4 net063 S VDD VDD pm1p2_svt_lp W=320n L=60n m=1
MPM3 net44 D net063 VDD pm1p2_svt_lp W=320n L=60n m=1
MPM2 net066 S VDD VDD pm1p2_svt_lp W=150n L=60n m=1
MPM1 net057 netqn net066 VDD pm1p2_svt_lp W=150n L=60n m=1
MPM0 netq G net057 VDD pm1p2_svt_lp W=150n L=60n m=1
XI0 netq VDD VSS Q / INV pl=6E-08 pw=2.8E-07 nl=6E-08 nw=2E-07
XI2 netq VDD VSS netqn / INV pl=6E-08 pw=2.8E-07 nl=6E-08 nw=2E-07
XI1 netqn VDD VSS QN / INV pl=6E-08 pw=2.8E-07 nl=6E-08 nw=2E-07
XI3 GN VDD VSS G / INV pl=6E-08 pw=2.8E-07 nl=6E-08 nw=2E-07
XI4 G VDD VSS GB / INV pl=6E-08 pw=2.8E-07 nl=6E-08 nw=2E-07
XI5 SN VDD VSS S / INV pl=6E-08 pw=2.8E-07 nl=6E-08 nw=2E-07
XI7 G GB net44 netq VDD VSS / TG pl=6E-08 pw=3.2E-07 nl=6E-08 nw=2E-07
.ENDS
