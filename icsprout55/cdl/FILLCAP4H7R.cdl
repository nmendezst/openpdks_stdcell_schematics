.SUBCKT FILLCAP4H7R VDD VSS
*.PININFO VDD:B VSS:B
MMM1 net1 net3 VSS VSS nm1p2_svt_lp W=200n L=380n m=1
MMM0 net3 net1 VDD VDD pm1p2_svt_lp W=300n L=380n m=1
.ENDS
