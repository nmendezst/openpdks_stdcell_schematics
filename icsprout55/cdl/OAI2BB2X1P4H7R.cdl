.SUBCKT OAI2BB2X1P4H7R A0N A1N B0 B1 VDD VSS Y
*.PININFO A0N:I A1N:I B0:I B1:I Y:O VDD:B VSS:B
MNM3 net8 B1 VSS VSS nm1p2_svt_lp W=245n L=60n m=1
MNM2 Y net35 net8 VSS nm1p2_svt_lp W=245n L=60n m=1
MNM1 net8 B0 VSS VSS nm1p2_svt_lp W=245n L=60n m=1
MNM0 net48 A1N VSS VSS nm1p2_svt_lp W=150n L=60n m=1
MMN10 net35 A0N net48 VSS nm1p2_svt_lp W=150n L=60n m=1
MPM2 net058 B0 VDD VDD pm1p2_svt_lp W=314n L=60n m=1
MPM1 Y net35 VDD VDD pm1p2_svt_lp W=314n L=60n m=1
MMP8 net35 A0N VDD VDD pm1p2_svt_lp W=190n L=60n m=1
MPM3 Y B1 net058 VDD pm1p2_svt_lp W=314n L=60n m=1
MPM0 net35 A1N VDD VDD pm1p2_svt_lp W=190n L=60n m=1
.ENDS
