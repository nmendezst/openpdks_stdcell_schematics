.SUBCKT AND4X2H7R A B C D VDD VSS Y
*.PININFO A:I B:I C:I D:I Y:O VDD:B VSS:B
MNM4 net35 D net45 VSS nm1p2_svt_lp W=170n L=60n m=1
MNM5 net45 C net42 VSS nm1p2_svt_lp W=170n L=60n m=1
MNM6 net42 B net39 VSS nm1p2_svt_lp W=170n L=60n m=1
MNM7 net39 A VSS VSS nm1p2_svt_lp W=170n L=60n m=1
MPM4 net35 A VDD VDD pm1p2_svt_lp W=150n L=60n m=1
MPM5 net35 B VDD VDD pm1p2_svt_lp W=150n L=60n m=1
MPM6 net35 C VDD VDD pm1p2_svt_lp W=150n L=60n m=1
MPM7 net35 D VDD VDD pm1p2_svt_lp W=150n L=60n m=1
XXI2 net35 VDD VSS Y / INV pl=6e-08 pw=3.8e-07 nl=6e-08 nw=3e-07
.ENDS
