.SUBCKT AOI221X0P5H7R A0 A1 B0 B1 C0 VDD VSS Y
*.PININFO A0:I A1:I B0:I B1:I C0:I Y:O VDD:B VSS:B
MMNM4 Y C0 VSS VSS nm1p2_svt_lp W=150n L=60n m=1
MMNM3 net31 B0 VSS VSS nm1p2_svt_lp W=150n L=60n m=1
MMNM2 Y B1 net31 VSS nm1p2_svt_lp W=150n L=60n m=1
MMNM1 net1 A0 VSS VSS nm1p2_svt_lp W=150n L=60n m=1
MMNM0 Y A1 net1 VSS nm1p2_svt_lp W=150n L=60n m=1
MMPM4 Y C0 net7 VDD pm1p2_svt_lp W=190n L=60n m=1
MMPM3 net7 B1 net5 VDD pm1p2_svt_lp W=190n L=60n m=1
MMPM2 net7 B0 net5 VDD pm1p2_svt_lp W=190n L=60n m=1
MMPM1 net5 A1 VDD VDD pm1p2_svt_lp W=190n L=60n m=1
MMPM0 net5 A0 VDD VDD pm1p2_svt_lp W=190n L=60n m=1
.ENDS
