.SUBCKT DFFNRX4H7R CKN D Q QN RN VDD VSS
*.PININFO CKN:I D:I RN:I Q:O QN:O VDD:B VSS:B
MMN1 net085 CKB net36 VSS nm1p2_svt_lp W=150n L=60n m=1
MMN2 net36 net0124 VSS VSS nm1p2_svt_lp W=150n L=60n m=1
MMN5 net085 R VSS VSS nm1p2_svt_lp W=200n L=60n m=1
MMN4 net46 net33 VSS VSS nm1p2_svt_lp W=260n L=60n m=1
MMP4 net54 R VDD VDD pm1p2_svt_lp W=360n L=60n m=1
MMP2 net67 net0124 net54 VDD pm1p2_svt_lp W=150n L=60n m=1
MMP1 net085 CKP net67 VDD pm1p2_svt_lp W=150n L=60n m=1
MMP3 net46 net33 net54 VDD pm1p2_svt_lp W=360n L=60n m=1
XXI29 net46 CKP CKB VDD VSS net33 / TSINV pl=6E-08 pw=1.5E-07 nl=6E-08 nw=1.5E-07
XI3 D CKB CKP VDD VSS net33 / TSINV pl=6E-08 pw=3.2E-07 nl=6E-08 nw=2.6E-07
XI11 net085 VDD VSS QN / INV pl=6E-08 pw=8E-07 nl=6E-08 nw=5.6E-07
XI7 CKP VDD VSS CKB / INV pl=6E-08 pw=3.4E-07 nl=6E-08 nw=2.4E-07
XI5 net0124 VDD VSS Q / INV pl=6E-08 pw=8E-07 nl=6E-08 nw=5.6E-07
XI8 RN VDD VSS R / INV pl=6E-08 pw=3.4E-07 nl=6E-08 nw=2.4E-07
XI9 net085 VDD VSS net0124 / INV pl=6E-08 pw=3.6E-07 nl=6E-08 nw=2.6E-07
XI0 CKN VDD VSS CKP / INV pl=6E-08 pw=3.4E-07 nl=6E-08 nw=2.4E-07
XXI9 CKP CKB net46 net085 VDD VSS / TG pl=6E-08 pw=3.35E-07 nl=6E-08 nw=2.6E-07
.ENDS
