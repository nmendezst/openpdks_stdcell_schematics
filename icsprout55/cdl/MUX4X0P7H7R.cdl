.SUBCKT MUX4X0P7H7R A B C D S0 S1 VDD VSS Y
*.PININFO A:I B:I C:I D:I S0:I S1:I Y:O VDD:B VSS:B
XXI9 S1 VDD VSS S1N / INV pl=60n pw=190n nl=60n nw=150n
XXI8 S0 VDD VSS S0N / INV pl=60n pw=190n nl=60n nw=150n
XXI1 net9 VDD VSS Y / INV pl=60n pw=222n nl=60n nw=174n
XXI10 S1N S1 net25 net9 VDD VSS / TG pl=60n pw=190n nl=60n nw=150n
XXI11 S1 S1N net17 net9 VDD VSS / TG pl=60n pw=190n nl=60n nw=150n
XXI7 D S0 S0N VDD VSS net17 / TSINV pl=60n pw=190n nl=60n nw=150n
XXI6 C S0N S0 VDD VSS net17 / TSINV pl=60n pw=190n nl=60n nw=150n
XXI5 B S0 S0N VDD VSS net25 / TSINV pl=60n pw=190n nl=60n nw=150n
XXI4 A S0N S0 VDD VSS net25 / TSINV pl=60n pw=190n nl=60n nw=150n
.ENDS
