.SUBCKT OAI2BB2X4H7R A0N A1N B0 B1 VDD VSS Y
*.PININFO A0N:I A1N:I B0:I B1:I Y:O VDD:B VSS:B
MNM6 net8 B1 VSS VSS nm1p2_svt_lp W=600n L=60n m=1
MNM5 net8 B0 VSS VSS nm1p2_svt_lp W=600n L=60n m=1
MNM2 Y net35 net8 VSS nm1p2_svt_lp W=600n L=60n m=1
MNM4 net48 A1N VSS VSS nm1p2_svt_lp W=250n L=60n m=1
MMN10 net35 A0N net48 VSS nm1p2_svt_lp W=250n L=60n m=1
MPM6 Y B1 net058 VDD pm1p2_svt_lp W=760n L=60n m=1
MPM1 Y net35 VDD VDD pm1p2_svt_lp W=760n L=60n m=1
MMP8 net35 A0N VDD VDD pm1p2_svt_lp W=310n L=60n m=1
MPM5 net058 B0 VDD VDD pm1p2_svt_lp W=760n L=60n m=1
MPM4 net35 A1N VDD VDD pm1p2_svt_lp W=310n L=60n m=1
.ENDS
