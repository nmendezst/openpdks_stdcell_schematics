.SUBCKT DLY2X6H7R A VDD VSS Y
*.PININFO A:I Y:O VDD:B VSS:B
XI0 A VDD VSS net013 / INV pl=60n pw=190n nl=60n nw=150n
XI1 net013 VDD VSS net014 / INV pl=120n pw=190n nl=120n nw=150n
XI2 net014 VDD VSS net015 / INV pl=120n pw=260n nl=120n nw=150n
XI3 net015 VDD VSS Y / INV pl=60n pw=1.14u nl=60n nw=570n
.ENDS
