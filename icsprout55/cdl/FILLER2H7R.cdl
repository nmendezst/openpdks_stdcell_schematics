.SUBCKT FILLER2H7R VDD VSS
*.PININFO VDD:B VSS:B
.ENDS
