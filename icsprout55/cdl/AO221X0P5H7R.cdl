.SUBCKT AO221X0P5H7R A0 A1 B0 B1 C0 VDD VSS Y
*.PININFO A0:I A1:I B0:I B1:I C0:I Y:O VDD:B VSS:B
MMNM4 net14 C0 VSS VSS nm1p2_svt_lp W=150n L=60n m=1
MMNM3 net31 B0 VSS VSS nm1p2_svt_lp W=150n L=60n m=1
MMNM2 net14 B1 net31 VSS nm1p2_svt_lp W=150n L=60n m=1
MMNM1 net39 A0 VSS VSS nm1p2_svt_lp W=150n L=60n m=1
MMNM0 net14 A1 net39 VSS nm1p2_svt_lp W=150n L=60n m=1
MMPM4 net14 C0 net15 VDD pm1p2_svt_lp W=190n L=60n m=1
MMPM3 net15 B1 net18 VDD pm1p2_svt_lp W=190n L=60n m=1
MMPM2 net15 B0 net18 VDD pm1p2_svt_lp W=190n L=60n m=1
MMPM1 net18 A1 VDD VDD pm1p2_svt_lp W=190n L=60n m=1
MMPM0 net18 A0 VDD VDD pm1p2_svt_lp W=190n L=60n m=1
XXI3 net14 VDD VSS Y / INV pl=60n pw=190n nl=60n nw=150n
.ENDS
