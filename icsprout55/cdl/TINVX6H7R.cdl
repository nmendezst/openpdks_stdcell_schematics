.SUBCKT TINVX6H7R A OE VDD VSS Y
*.PININFO A:I OE:I Y:O VDD:B VSS:B
MNM7 Y net9 VSS VSS nm1p2_svt_lp W=900n L=60n m=1
MNM6 net9 OEN VSS VSS nm1p2_svt_lp W=900n L=60n m=1
MNM5 net9 net27 VSS VSS nm1p2_svt_lp W=900n L=60n m=1
MPM7 Y net031 VDD VDD pm1p2_svt_lp W=1.14u L=60n m=1
MPM6 net031 OE VDD VDD pm1p2_svt_lp W=1.14u L=60n m=1
MPM5 net031 net27 VDD VDD pm1p2_svt_lp W=1.14u L=60n m=1
XI5 A VDD VSS net27 / INV pl=6E-08 pw=1.14e-06 nl=6E-08 nw=9e-07
XI3 OE VDD VSS OEN / INV pl=6E-08 pw=3.8e-07 nl=6E-08 nw=3e-07
XI4 OE OEN net9 net031 VDD VSS / TG pl=6E-08 pw=1.14e-06 nl=6E-08 nw=9e-07
.ENDS
