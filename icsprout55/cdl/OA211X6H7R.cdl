.SUBCKT OA211X6H7R A0 A1 B0 C0 VDD VSS Y
*.PININFO A0:I A1:I B0:I C0:I Y:O VDD:B VSS:B
MMNM3 net10 C0 net30 VSS nm1p2_svt_lp W=300n L=60n m=1
MNM4 net22 A0 VSS VSS nm1p2_svt_lp W=300n L=60n m=1
MNM3 net30 B0 net22 VSS nm1p2_svt_lp W=300n L=60n m=1
MNM5 net22 A1 VSS VSS nm1p2_svt_lp W=300n L=60n m=1
MMPM1 net10 A1 net13 VDD pm1p2_svt_lp W=380n L=60n m=1
MPM5 net10 C0 VDD VDD pm1p2_svt_lp W=380n L=60n m=1
MPM3 net13 A0 VDD VDD pm1p2_svt_lp W=380n L=60n m=1
MPM4 net10 B0 VDD VDD pm1p2_svt_lp W=380n L=60n m=1
XXI3 net10 VDD VSS Y / INV pl=6e-08 pw=11.4e-07 nl=6e-08 nw=9e-07
.ENDS
