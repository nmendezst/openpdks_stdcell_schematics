.SUBCKT TG CK CKN D Q VDD VSS
*.PININFO CK:I CKN:I D:B Q:B VDD:B VSS:B
MMN0 D CK Q VSS nm1p2_svt_lp W=nw L=nl m=1
MMP0 D CKN Q VDD pm1p2_svt_lp W=pw L=pl m=1
.ENDS
