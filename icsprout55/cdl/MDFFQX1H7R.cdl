.SUBCKT MDFFQX1H7R CK D0 D1 Q S0 VDD VSS
*.PININFO CK:I D0:I D1:I S0:I Q:O VDD:B VSS:B
XXI18 net32 net24 net034 net33 VDD VSS / TG pl=60n pw=280n nl=60n nw=200n
XXI14 net46 net24 net32 VDD VSS net33 / TSINV pl=60n pw=150n nl=60n nw=150n
XXI19 D1 S0 net057 VDD VSS net034 / TSINV pl=60n pw=280n nl=60n nw=200n
XXI20 D0 net057 S0 VDD VSS net034 / TSINV pl=60n pw=280n nl=60n nw=200n
XXI9 net46 net24 net32 VDD VSS net25 / TSINV pl=60n pw=280n nl=60n nw=200n
XXI15 net9 net32 net24 VDD VSS net25 / TSINV pl=60n pw=150n nl=60n nw=150n
XXI21 S0 VDD VSS net057 / INV pl=60n pw=280n nl=60n nw=200n
XXI7 net33 VDD VSS net46 / INV pl=60n pw=280n nl=60n nw=200n
XXI13 net32 VDD VSS net24 / INV pl=60n pw=280n nl=60n nw=200n
XXI12 net25 VDD VSS Q / INV pl=60n pw=340n nl=60n nw=240n
XXI10 net25 VDD VSS net9 / INV pl=60n pw=300n nl=60n nw=220n
XXI4 CK VDD VSS net32 / INV pl=60n pw=280n nl=60n nw=200n
.ENDS
