.SUBCKT AO31X2H7R A0 A1 A2 B0 VDD VSS Y
*.PININFO A0:I A1:I A2:I B0:I Y:O VDD:B VSS:B
XXI3 net35 VDD VSS Y / INV pl=60n pw=380n nl=60n nw=300n
MMPM2 net42 A2 VDD VDD pm1p2_svt_lp W=190n L=60n m=1
MMPM3 net35 B0 net42 VDD pm1p2_svt_lp W=190n L=60n m=1
MMPM1 net42 A1 VDD VDD pm1p2_svt_lp W=190n L=60n m=1
MMPM0 net42 A0 VDD VDD pm1p2_svt_lp W=190n L=60n m=1
MMNM0 net35 A2 net34 VSS nm1p2_svt_lp W=150n L=60n m=1
MMNM1 net34 A1 net33 VSS nm1p2_svt_lp W=150n L=60n m=1
MMNM3 net35 B0 VSS VSS nm1p2_svt_lp W=150n L=60n m=1
MMNM2 net33 A0 VSS VSS nm1p2_svt_lp W=150n L=60n m=1
.ENDS
