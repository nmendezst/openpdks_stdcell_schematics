.SUBCKT AOI21X0P7H7R A0 A1 B0 VDD VSS Y
*.PININFO A0:I A1:I B0:I Y:O VDD:B VSS:B
MMP1 net31 A1 VDD VDD pm1p2_svt_lp W=222n L=60n m=1
MMP2 Y B0 net31 VDD pm1p2_svt_lp W=222n L=60n m=1
MMP0 net31 A0 VDD VDD pm1p2_svt_lp W=222n L=60n m=1
MMN0 Y B0 VSS VSS nm1p2_svt_lp W=175n L=60n m=1
MMN1 Y A1 net33 VSS nm1p2_svt_lp W=175n L=60n m=1
MMN4 net33 A0 VSS VSS nm1p2_svt_lp W=175n L=60n m=1
.ENDS
