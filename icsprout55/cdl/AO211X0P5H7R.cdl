.SUBCKT AO211X0P5H7R A0 A1 B0 C0 VDD VSS Y
*.PININFO A0:I A1:I B0:I C0:I Y:O VDD:B VSS:B
MMNM3 net21 B0 VSS VSS nm1p2_svt_lp W=150n L=60n m=1
MMNM2 net21 C0 VSS VSS nm1p2_svt_lp W=150n L=60n m=1
MMNM1 net5 A0 VSS VSS nm1p2_svt_lp W=150n L=60n m=1
MMNM0 net21 A1 net5 VSS nm1p2_svt_lp W=150n L=60n m=1
MMPM3 net21 C0 net8 VDD pm1p2_svt_lp W=190n L=60n m=1
MMPM2 net8 B0 net7 VDD pm1p2_svt_lp W=190n L=60n m=1
MMPM1 net7 A1 VDD VDD pm1p2_svt_lp W=190n L=60n m=1
MMPM0 net7 A0 VDD VDD pm1p2_svt_lp W=190n L=60n m=1
XXI1 net21 VDD VSS Y / INV pl=60n pw=190n nl=60n nw=150n
.ENDS
