.SUBCKT AO22X0P5H7R A0 A1 B0 B1 VDD VSS Y
*.PININFO A0:I A1:I B0:I B1:I Y:O VDD:B VSS:B
MMNM3 net9 A0 VSS VSS nm1p2_svt_lp W=150n L=60n m=1
MMNM2 net13 A1 net9 VSS nm1p2_svt_lp W=150n L=60n m=1
MMNM1 net8 B0 VSS VSS nm1p2_svt_lp W=150n L=60n m=1
MMNM0 net13 B1 net8 VSS nm1p2_svt_lp W=150n L=60n m=1
MMPM3 net13 B1 net17 VDD pm1p2_svt_lp W=190n L=60n m=1
MMPM2 net17 A1 VDD VDD pm1p2_svt_lp W=190n L=60n m=1
MMPM1 net13 B0 net17 VDD pm1p2_svt_lp W=190n L=60n m=1
MMPM0 net17 A0 VDD VDD pm1p2_svt_lp W=190n L=60n m=1
XXI1 net13 VDD VSS Y / INV pl=60n pw=190n nl=60n nw=150n
.ENDS
