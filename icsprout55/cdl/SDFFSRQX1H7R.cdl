.SUBCKT SDFFSRQX1H7R CK D Q RN SE SI SN VDD VSS
*.PININFO CK:I D:I RN:I SE:I SI:I SN:I Q:O VDD:B VSS:B
MMN5 net062 SN VSS VSS nm1p2_svt_lp W=150n L=60n m=1
MMN1 net0115 cn net36 VSS nm1p2_svt_lp W=150n L=60n m=1
MMN2 net36 net093 net062 VSS nm1p2_svt_lp W=150n L=60n m=1
MMN6 net0115 r net062 VSS nm1p2_svt_lp W=150n L=60n m=1
MMN4 net46 net33 net062 VSS nm1p2_svt_lp W=190n L=60n m=1
MMP4 net0115 SN VDD VDD pm1p2_svt_lp W=150n L=60n m=1
MMP5 net54 r VDD VDD pm1p2_svt_lp W=150n L=60n m=1
MMP2 net67 net093 net54 VDD pm1p2_svt_lp W=150n L=60n m=1
MMP1 net0115 c net67 VDD pm1p2_svt_lp W=150n L=60n m=1
MMP3 net46 net33 net54 VDD pm1p2_svt_lp W=170n L=60n m=1
XXI33 SI SE sen VDD VSS net088 / TSINV pl=60n pw=150n nl=60n nw=150n
XXI29 net46 c cn VDD VSS net33 / TSINV pl=60n pw=150n nl=60n nw=150n
XXI30 D sen SE VDD VSS net088 / TSINV pl=60n pw=250n nl=60n nw=180n
XXI35 cn c net088 net33 VDD VSS / TG pl=60n pw=190n nl=60n nw=150n
XXI9 c cn net46 net0115 VDD VSS / TG pl=60n pw=190n nl=60n nw=150n
XXI32 RN VDD VSS r / INV pl=60n pw=210n nl=60n nw=170n
XXI34 SE VDD VSS sen / INV pl=60n pw=210n nl=60n nw=170n
XXI5 net093 VDD VSS Q / INV pl=60n pw=270n nl=60n nw=210n
XXI13 cn VDD VSS c / INV pl=60n pw=210n nl=60n nw=170n
XXI10 net0115 VDD VSS net093 / INV pl=60n pw=190n nl=60n nw=150n
XXI4 CK VDD VSS cn / INV pl=60n pw=210n nl=60n nw=170n
.ENDS
