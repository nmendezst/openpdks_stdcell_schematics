.SUBCKT NOR3BX0P5H7R AN B C VDD VSS Y
*.PININFO AN:I B:I C:I Y:O VDD:B VSS:B
MMN3 Y net17 VSS VSS nm1p2_svt_lp W=150n L=60n m=1
MMN2 Y C VSS VSS nm1p2_svt_lp W=150n L=60n m=1
MMN0 Y B VSS VSS nm1p2_svt_lp W=150n L=60n m=1
MMP3 Y C net026 VDD pm1p2_svt_lp W=190n L=60n m=1
MMP1 net020 net17 VDD VDD pm1p2_svt_lp W=190n L=60n m=1
MMP2 net026 B net020 VDD pm1p2_svt_lp W=190n L=60n m=1
XXI3 AN VDD VSS net17 / INV pl=6e-08 pw=1.9e-07 nl=6e-08 nw=1.5e-07
.ENDS
