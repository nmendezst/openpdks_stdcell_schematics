.SUBCKT LATHX4H7R D G Q QN VDD VSS
*.PININFO D:I G:I Q:O QN:O VDD:B VSS:B
XXI6 D GP GN VDD VSS net25 / TSINV pl=6e-08 pw=3.4e-07 nl=6e-08 nw=2.4e-07
XXI15 net9 GN GP VDD VSS net25 / TSINV pl=60n pw=150n nl=60n nw=150n
XXI4 G VDD VSS GN / INV pl=60n pw=280n nl=60n nw=200n
XXI13 GN VDD VSS GP / INV pl=60n pw=340n nl=60n nw=240n
XXI7 net25 VDD VSS net9 / INV pl=60n pw=280n nl=60n nw=200n
XI3 net25 VDD VSS Q / INV pl=60n pw=800n nl=60n nw=560n
XI1 net9 VDD VSS QN / INV pl=60n pw=800n nl=60n nw=560n
.ENDS
