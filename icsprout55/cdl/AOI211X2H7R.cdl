.SUBCKT AOI211X2H7R A0 A1 B0 C0 VDD VSS Y
*.PININFO A0:I A1:I B0:I C0:I Y:O VDD:B VSS:B
MMN0 Y C0 VSS VSS nm1p2_svt_lp W=300n L=60n m=1
MMN1 Y A1 net34 VSS nm1p2_svt_lp W=300n L=60n m=1
MMN4 net34 A0 VSS VSS nm1p2_svt_lp W=300n L=60n m=1
MMN5 Y B0 VSS VSS nm1p2_svt_lp W=300n L=60n m=1
MMP0 net31 A0 VDD VDD pm1p2_svt_lp W=380n L=60n m=1
MMP1 net31 A1 VDD VDD pm1p2_svt_lp W=380n L=60n m=1
MMP2 net33 C0 net31 VDD pm1p2_svt_lp W=380n L=60n m=1
MMP3 Y B0 net33 VDD pm1p2_svt_lp W=380n L=60n m=1
.ENDS
