.SUBCKT AOI32X2H7R A0 A1 A2 B0 B1 VDD VSS Y
*.PININFO A0:I A1:I A2:I B0:I B1:I Y:O VDD:B VSS:B
MMP3 net42 A1 VDD VDD pm1p2_svt_lp W=380n L=60n m=1
MMP4 Y B0 net42 VDD pm1p2_svt_lp W=380n L=60n m=1
MMP2 Y B1 net42 VDD pm1p2_svt_lp W=380n L=60n m=1
MMP0 net42 A0 VDD VDD pm1p2_svt_lp W=380n L=60n m=1
MMP1 net42 A2 VDD VDD pm1p2_svt_lp W=380n L=60n m=1
MMN0 Y B1 net36 VSS nm1p2_svt_lp W=300n L=60n m=1
MMN1 Y A2 net35 VSS nm1p2_svt_lp W=300n L=60n m=1
MMN4 net35 A1 net34 VSS nm1p2_svt_lp W=300n L=60n m=1
MMN6 net36 B0 VSS VSS nm1p2_svt_lp W=300n L=60n m=1
MMN5 net34 A0 VSS VSS nm1p2_svt_lp W=300n L=60n m=1
.ENDS
