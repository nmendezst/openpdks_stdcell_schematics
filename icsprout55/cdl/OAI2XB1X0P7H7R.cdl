.SUBCKT OAI2XB1X0P7H7R A0 A1N B0 VDD VSS Y
*.PININFO A0:I A1N:I B0:I Y:O VDD:B VSS:B
MMNM2 Y B0 net17 VSS nm1p2_svt_lp W=174n L=60n m=1
MMNM1 net17 A1 VSS VSS nm1p2_svt_lp W=174n L=60n m=1
MMNM0 net17 A0 VSS VSS nm1p2_svt_lp W=174n L=60n m=1
MMPM1 Y A1 net12 VDD pm1p2_svt_lp W=222n L=60n m=1
MMPM2 Y B0 VDD VDD pm1p2_svt_lp W=222n L=60n m=1
MMPM0 net12 A0 VDD VDD pm1p2_svt_lp W=222n L=60n m=1
XXI3 A1N VDD VSS A1 / INV pl=6e-08 pw=1.9e-07 nl=6e-08 nw=1.5e-07
.ENDS
