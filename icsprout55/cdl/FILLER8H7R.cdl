.SUBCKT FILLER8H7R VDD VSS
*.PININFO VDD:B VSS:B
.ENDS
