.SUBCKT NAND2X16H7R A B VDD VSS Y
*.PININFO A:I B:I Y:O VDD:B VSS:B
MMM1 Y B VDD VDD pm1p2_svt_lp W=3.04u L=60n m=1
MMM0 Y A VDD VDD pm1p2_svt_lp W=3.04u L=60n m=1
MMM3 Y B net12 VSS nm1p2_svt_lp W=2.4u L=60n m=1
MMM2 net12 A VSS VSS nm1p2_svt_lp W=2.4u L=60n m=1
.ENDS
