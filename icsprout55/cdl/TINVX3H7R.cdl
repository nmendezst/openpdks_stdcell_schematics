.SUBCKT TINVX3H7R A OE VDD VSS Y
*.PININFO A:I OE:I Y:O VDD:B VSS:B
XI3 OE OEN net9 net031 VDD VSS / TG pl=6E-08 pw=5.7e-07 nl=6E-08 nw=4.5e-07
MNM7 net9 net27 VSS VSS nm1p2_svt_lp W=450n L=60n m=1
MNM9 Y net9 VSS VSS nm1p2_svt_lp W=450n L=60n m=1
MNM8 net9 OEN VSS VSS nm1p2_svt_lp W=450n L=60n m=1
MPM8 net031 OE VDD VDD pm1p2_svt_lp W=570n L=60n m=1
MPM9 Y net031 VDD VDD pm1p2_svt_lp W=570n L=60n m=1
MPM5 net031 net27 VDD VDD pm1p2_svt_lp W=570n L=60n m=1
XI5 OE VDD VSS OEN / INV pl=6E-08 pw=3.1e-07 nl=6E-08 nw=2.5e-07
XI4 A VDD VSS net27 / INV pl=6E-08 pw=5.7e-07 nl=6E-08 nw=4.5e-07
.ENDS
