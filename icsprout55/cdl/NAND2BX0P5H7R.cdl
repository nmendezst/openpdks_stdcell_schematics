.SUBCKT NAND2BX0P5H7R AN B VDD VSS Y
*.PININFO AN:I B:I Y:O VDD:B VSS:B
MMN0 Y B net6 VSS nm1p2_svt_lp W=150n L=60n m=1
MMN1 net6 net14 VSS VSS nm1p2_svt_lp W=150n L=60n m=1
MMP1 Y net14 VDD VDD pm1p2_svt_lp W=190n L=60n m=1
MMP0 Y B VDD VDD pm1p2_svt_lp W=190n L=60n m=1
XXI3 AN VDD VSS net14 / INV pl=6e-08 pw=1.9e-07 nl=6e-08 nw=1.5e-07
.ENDS
