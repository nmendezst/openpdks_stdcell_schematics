.SUBCKT AOI31X0P5H7R A0 A1 A2 B0 VDD VSS Y
*.PININFO A0:I A1:I A2:I B0:I Y:O VDD:B VSS:B
MMN5 net37 A0 VSS VSS nm1p2_svt_lp W=150n L=60n m=1
MMN4 net12 A1 net37 VSS nm1p2_svt_lp W=150n L=60n m=1
MMN1 Y A2 net12 VSS nm1p2_svt_lp W=150n L=60n m=1
MMN0 Y B0 VSS VSS nm1p2_svt_lp W=150n L=60n m=1
MMP2 Y B0 net8 VDD pm1p2_svt_lp W=190n L=60n m=1
MMP3 net8 A1 VDD VDD pm1p2_svt_lp W=190n L=60n m=1
MMP1 net8 A2 VDD VDD pm1p2_svt_lp W=190n L=60n m=1
MMP0 net8 A0 VDD VDD pm1p2_svt_lp W=190n L=60n m=1
.ENDS
