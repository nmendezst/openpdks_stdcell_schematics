.SUBCKT LATHSX1H7R D G Q QN SN VDD VSS
*.PININFO D:I G:I SN:I Q:O QN:O VDD:B VSS:B
MNM1 net44 D VSS VSS nm1p2_svt_lp W=200n L=60n m=1
MNM2 netq S VSS VSS nm1p2_svt_lp W=200n L=60n m=1
MMN1 netq GN net38 VSS nm1p2_svt_lp W=150n L=60n m=1
MMN4 net38 netqn VSS VSS nm1p2_svt_lp W=150n L=60n m=1
MPM2 net44 D net062 VDD pm1p2_svt_lp W=320n L=60n m=1
MPM1 net065 S VDD VDD pm1p2_svt_lp W=150n L=60n m=1
MPM0 net056 netqn net065 VDD pm1p2_svt_lp W=150n L=60n m=1
MPM4 net062 S VDD VDD pm1p2_svt_lp W=320n L=60n m=1
MMP4 netq GP net056 VDD pm1p2_svt_lp W=150n L=60n m=1
XI10 GN VDD VSS GP / INV pl=6E-08 pw=2.8E-07 nl=6E-08 nw=2E-07
XI3 G VDD VSS GN / INV pl=6E-08 pw=2.8E-07 nl=6E-08 nw=2E-07
XI0 netq VDD VSS Q / INV pl=6E-08 pw=3.4E-07 nl=6E-08 nw=2.4E-07
XI12 netq VDD VSS netqn / INV pl=6E-08 pw=2.8E-07 nl=6E-08 nw=2E-07
XI13 netqn VDD VSS QN / INV pl=6E-08 pw=3.4E-07 nl=6E-08 nw=2.4E-07
XI11 SN VDD VSS S / INV pl=6E-08 pw=2.8E-07 nl=6E-08 nw=2E-07
XI7 GP GN net44 netq VDD VSS / TG pl=6E-08 pw=3.2E-07 nl=6E-08 nw=2E-07
.ENDS
