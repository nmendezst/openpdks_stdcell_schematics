.SUBCKT TBUFX16H7R A OE VDD VSS Y
*.PININFO A:I OE:I Y:O VDD:B VSS:B
MNM0 net45 OEN VSS VSS nm1p2_svt_lp W=2.32u L=60n m=1
MNM2 net45 A VSS VSS nm1p2_svt_lp W=900n L=60n m=1
MNM1 Y net45 VSS VSS nm1p2_svt_lp W=2.4u L=60n m=1
MPM0 Y net29 VDD VDD pm1p2_svt_lp W=3.04u L=60n m=1
MPM1 net29 OE VDD VDD pm1p2_svt_lp W=2.96u L=60n m=1
MPM2 net29 A VDD VDD pm1p2_svt_lp W=1.14u L=60n m=1
XI1 OE VDD VSS OEN / INV pl=6e-08 pw=1.14e-06 nl=6e-08 nw=9e-07
XI0 OE OEN net45 net29 VDD VSS / TG pl=6e-08 pw=1.14e-06 nl=6e-08 nw=9e-07
.ENDS
