.SUBCKT MSDFFQX0P5H7R CK D0 D1 Q S0 SE SI VDD VSS
*.PININFO CK:I D0:I D1:I S0:I SE:I SI:I Q:O VDD:B VSS:B
XXI21 c cn net46 net25 VDD VSS / TG pl=60n pw=280n nl=60n nw=200n
XXI20 SEN SE net034 net046 VDD VSS / TG pl=60n pw=300n nl=60n nw=220n
XXI14 net46 c cn VDD VSS net33 / TSINV pl=60n pw=150n nl=60n nw=150n
XXI24 D1 S0 S0N VDD VSS net034 / TSINV pl=60n pw=280n nl=60n nw=200n
XXI25 D0 S0N S0 VDD VSS net034 / TSINV pl=60n pw=280n nl=60n nw=200n
XXI22 SI SE SEN VDD VSS net046 / TSINV pl=60n pw=280n nl=60n nw=200n
XXI19 net046 cn c VDD VSS net33 / TSINV pl=60n pw=300n nl=60n nw=220n
XXI15 net9 cn c VDD VSS net25 / TSINV pl=60n pw=150n nl=60n nw=150n
XXI26 S0 VDD VSS S0N / INV pl=60n pw=280n nl=60n nw=200n
XXI23 SE VDD VSS SEN / INV pl=60n pw=280n nl=60n nw=200n
XXI7 net33 VDD VSS net46 / INV pl=60n pw=280n nl=60n nw=200n
XXI13 cn VDD VSS c / INV pl=60n pw=280n nl=60n nw=200n
XXI12 net25 VDD VSS Q / INV pl=60n pw=280n nl=60n nw=200n
XXI10 net25 VDD VSS net9 / INV pl=60n pw=280n nl=60n nw=200n
XXI4 CK VDD VSS cn / INV pl=60n pw=280n nl=60n nw=200n
.ENDS
