.SUBCKT AOI2BB1X2H7R A0N A1N B0 VDD VSS Y
*.PININFO A0N:I A1N:I B0:I Y:O VDD:B VSS:B
MMN6 net54 A1N VSS VSS nm1p2_svt_lp W=150n L=60n m=1
MMN7 Y net54 VSS VSS nm1p2_svt_lp W=300n L=60n m=1
MMN4 Y B0 VSS VSS nm1p2_svt_lp W=300n L=60n m=1
MMN5 net54 A0N VSS VSS nm1p2_svt_lp W=150n L=60n m=1
MMP1 net56 net54 VDD VDD pm1p2_svt_lp W=380n L=60n m=1
MMP2 Y B0 net56 VDD pm1p2_svt_lp W=380n L=60n m=1
MMP3 net57 A0N VDD VDD pm1p2_svt_lp W=190n L=60n m=1
MMP4 net54 A1N net57 VDD pm1p2_svt_lp W=190n L=60n m=1
.ENDS
