.SUBCKT MUX2X1H7R A B S0 VDD VSS Y
*.PININFO A:I B:I S0:I Y:O VDD:B VSS:B
XXI0 S0 VDD VSS S0N / INV pl=60n pw=190n nl=60n nw=150n
XXI2 net19 VDD VSS Y / INV pl=60n pw=270n nl=60n nw=210n
XXI3 A S0N S0 VDD VSS net19 / TSINV pl=60n pw=190n nl=60n nw=150n
XXI5 B S0 S0N VDD VSS net19 / TSINV pl=60n pw=190n nl=60n nw=150n
.ENDS
