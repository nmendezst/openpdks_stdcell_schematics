.SUBCKT XNOR3X1P4H7R A B C VDD VSS Y
*.PININFO A:I B:I C:I Y:O VDD:B VSS:B
XXI16 AN A BN net45 VDD VSS / TG pl=60n pw=190n nl=60n nw=150n
XXI14 net57 net45 CN net49 VDD VSS / TG pl=60n pw=190n nl=60n nw=150n
XXI18 BN A AN VDD VSS net45 / TSINV pl=60n pw=190n nl=60n nw=150n
XXI13 CN net45 net57 VDD VSS net49 / TSINV pl=60n pw=190n nl=60n nw=150n
XXI15 net45 VDD VSS net57 / INV pl=60n pw=190n nl=60n nw=150n
XXI17 B VDD VSS BN / INV pl=60n pw=220n nl=60n nw=175n
XXI11 net49 VDD VSS Y / INV pl=60n pw=325n nl=60n nw=255n
XXI19 A VDD VSS AN / INV pl=60n pw=190n nl=60n nw=150n
XXI12 C VDD VSS CN / INV pl=60n pw=190n nl=60n nw=150n
.ENDS
