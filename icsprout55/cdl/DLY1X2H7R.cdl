.SUBCKT DLY1X2H7R A VDD VSS Y
*.PININFO A:I Y:O VDD:B VSS:B
XI3 net1 VDD VSS Y / INV pl=60n pw=380n nl=60n nw=190n
XI2 net2 VDD VSS net1 / INV pl=60n pw=270n nl=60n nw=150n
XI1 net3 VDD VSS net2 / INV pl=60n pw=190n nl=60n nw=150n
XI0 A VDD VSS net3 / INV pl=60n pw=190n nl=60n nw=150n
.ENDS
