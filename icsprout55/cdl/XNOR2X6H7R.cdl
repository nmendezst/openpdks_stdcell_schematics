.SUBCKT XNOR2X6H7R A B VDD VSS Y
*.PININFO A:I B:I Y:O VDD:B VSS:B
XXI4 A AN BN net19 VDD VSS / TG pl=60n pw=210n nl=60n nw=170n
XXI0 A VDD VSS AN / INV pl=60n pw=250n nl=60n nw=200n
XXI7 B VDD VSS BN / INV pl=60n pw=380n nl=60n nw=300n
XXI9 net19 VDD VSS Y / INV pl=60n pw=1140n nl=60n nw=900n
XXI10 BN AN A VDD VSS net19 / TSINV pl=60n pw=310n nl=60n nw=250n
.ENDS
