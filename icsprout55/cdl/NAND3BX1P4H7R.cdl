.SUBCKT NAND3BX1P4H7R AN B C VDD VSS Y
*.PININFO AN:I B:I C:I Y:O VDD:B VSS:B
MMN3 net10 B net7 VSS nm1p2_svt_lp W=245n L=60n m=1
MMN4 net7 net20 VSS VSS nm1p2_svt_lp W=245n L=60n m=1
MMN0 Y C net10 VSS nm1p2_svt_lp W=245n L=60n m=1
MMP2 Y C VDD VDD pm1p2_svt_lp W=314n L=60n m=1
MMP1 Y B VDD VDD pm1p2_svt_lp W=314n L=60n m=1
MMP0 Y net20 VDD VDD pm1p2_svt_lp W=314n L=60n m=1
XXI3 AN VDD VSS net20 / INV pl=6e-08 pw=1.9e-07 nl=6e-08 nw=1.5e-07
.ENDS
