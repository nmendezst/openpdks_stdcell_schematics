.SUBCKT NAND2X1P4H7R A B VDD VSS Y
*.PININFO A:I B:I Y:O VDD:B VSS:B
MMN0 Y B net6 VSS nm1p2_svt_lp W=246n L=60n m=1
MMN1 net6 A VSS VSS nm1p2_svt_lp W=246n L=60n m=1
MMP1 Y B VDD VDD pm1p2_svt_lp W=314n L=60n m=1
MMP0 Y A VDD VDD pm1p2_svt_lp W=314n L=60n m=1
.ENDS
