.SUBCKT OAI31X1P4H7R A0 A1 A2 B0 VDD VSS Y
*.PININFO A0:I A1:I A2:I B0:I Y:O VDD:B VSS:B
MMNM3 Y B0 net34 VSS nm1p2_svt_lp W=245n L=60n m=1
MMNM2 net34 A2 VSS VSS nm1p2_svt_lp W=245n L=60n m=1
MMNM1 net34 A1 VSS VSS nm1p2_svt_lp W=245n L=60n m=1
MMNM0 net34 A0 VSS VSS nm1p2_svt_lp W=245n L=60n m=1
MPM2 net17 A0 VDD VDD pm1p2_svt_lp W=314n L=60n m=1
MMPM3 Y B0 VDD VDD pm1p2_svt_lp W=314n L=60n m=1
MPM1 net13 A1 net17 VDD pm1p2_svt_lp W=314n L=60n m=1
MPM0 Y A2 net13 VDD pm1p2_svt_lp W=314n L=60n m=1
.ENDS
