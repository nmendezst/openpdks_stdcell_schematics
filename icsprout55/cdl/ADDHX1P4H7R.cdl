.SUBCKT ADDHX1P4H7R A B CO S VDD VSS
*.PININFO A:I B:I CO:O S:O VDD:B VSS:B
XI18 BN B net45 net_25 VDD VSS / TG pl=6E-08 pw=3.64E-07 nl=6E-08 nw=2.56E-07
XI9 B BN net034 net_25 VDD VSS / TG pl=6E-08 pw=3.64E-07 nl=6E-08 nw=2.56E-07
XI20 A VDD VSS net45 / INV pl=6E-08 pw=4E-07 nl=6E-08 nw=2.8E-07
XI15 net_25 VDD VSS S / INV pl=6E-08 pw=3.64E-07 nl=6E-08 nw=2.56E-07
XI17 B VDD VSS BN / INV pl=6E-08 pw=3.64E-07 nl=6E-08 nw=2.56E-07
XI16 net45 VDD VSS net034 / INV pl=6E-08 pw=3.64E-07 nl=6E-08 nw=2.56E-07
XI19 net_7 VDD VSS CO / INV pl=6E-08 pw=3.64E-07 nl=6E-08 nw=2.56E-07
XI11 B A VDD VSS net_7 / NAND2 pl=6E-08 pw=2E-07 nl=6E-08 nw=2E-07
.ENDS
