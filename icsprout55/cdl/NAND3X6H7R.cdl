.SUBCKT NAND3X6H7R A B C VDD VSS Y
*.PININFO A:I B:I C:I Y:O VDD:B VSS:B
MMN3 net10 B net7 VSS nm1p2_svt_lp W=900n L=60n m=1
MMN4 net7 A VSS VSS nm1p2_svt_lp W=900n L=60n m=1
MMN0 Y C net10 VSS nm1p2_svt_lp W=900n L=60n m=1
MMP2 Y C VDD VDD pm1p2_svt_lp W=1.14u L=60n m=1
MMP1 Y B VDD VDD pm1p2_svt_lp W=1.14u L=60n m=1
MMP0 Y A VDD VDD pm1p2_svt_lp W=1.14u L=60n m=1
.ENDS
