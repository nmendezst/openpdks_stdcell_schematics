.SUBCKT BUFX0P7H7R A VDD VSS Y
*.PININFO A:I Y:O VDD:B VSS:B
XXI1 net6 VDD VSS Y / INV pl=6e-08 pw=2.22e-07 nl=6e-08 nw=1.74e-07
XXI0 A VDD VSS net6 / INV pl=6e-08 pw=1.9e-07 nl=6e-08 nw=1.5e-07
.ENDS
