.SUBCKT DFFNSRQX1H7R CKN D Q RN SN VDD VSS
*.PININFO CKN:I D:I RN:I SN:I Q:O VDD:B VSS:B
XI3 net0144 VDD VSS Q / INV pl=6E-08 pw=2.7E-07 nl=6E-08 nw=2.1E-07
XI2 net094 VDD VSS net0144 / INV pl=6E-08 pw=2.1E-07 nl=6E-08 nw=1.7E-07
XI1 RN VDD VSS R / INV pl=6E-08 pw=1.7E-07 nl=6E-08 nw=1.5E-07
XI0 CKP VDD VSS CKB / INV pl=6E-08 pw=2.1E-07 nl=6E-08 nw=1.7E-07
XXI4 CKN VDD VSS CKP / INV pl=6E-08 pw=2.1E-07 nl=6E-08 nw=1.7E-07
XXI30 D CKB CKP VDD VSS net33 / TSINV pl=6E-08 pw=2E-07 nl=6E-08 nw=1.6E-07
XXI29 net46 CKP CKB VDD VSS net33 / TSINV pl=6E-08 pw=1.5E-07 nl=6E-08 nw=1.5E-07
MMN6 net094 R net062 VSS nm1p2_svt_lp W=150n L=60n m=1
MMN4 net46 net33 net062 VSS nm1p2_svt_lp W=170n L=60n m=1
MMN1 net094 CKB net36 VSS nm1p2_svt_lp W=150n L=60n m=1
MMN2 net36 net0144 net062 VSS nm1p2_svt_lp W=150n L=60n m=1
MMN5 net062 SN VSS VSS nm1p2_svt_lp W=150n L=60n m=1
XXI9 CKP CKB net46 net094 VDD VSS / TG pl=6E-08 pw=1.5E-07 nl=6E-08 nw=1.5E-07
MMP5 net54 R VDD VDD pm1p2_svt_lp W=150n L=60n m=1
MMP2 net67 net0144 net54 VDD pm1p2_svt_lp W=150n L=60n m=1
MMP3 net46 net33 net54 VDD pm1p2_svt_lp W=210n L=60n m=1
MMP4 net094 SN VDD VDD pm1p2_svt_lp W=170n L=60n m=1
MMP1 net094 CKP net67 VDD pm1p2_svt_lp W=150n L=60n m=1
.ENDS
