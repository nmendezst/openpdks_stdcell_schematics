.SUBCKT DFFSRX2H7R CK D Q QN RN SN VDD VSS
*.PININFO CK:I D:I RN:I SN:I Q:O QN:O VDD:B VSS:B
MMN5 net062 SN VSS VSS nm1p2_svt_lp W=260n L=60n m=1
MMN1 net093 CKN net36 VSS nm1p2_svt_lp W=150n L=60n m=1
MMN2 net36 net0144 net062 VSS nm1p2_svt_lp W=150n L=60n m=1
MMN6 net093 R net062 VSS nm1p2_svt_lp W=200n L=60n m=1
MMN4 net46 net33 net062 VSS nm1p2_svt_lp W=240n L=60n m=1
MMP4 net093 SN VDD VDD pm1p2_svt_lp W=200n L=60n m=1
MMP5 net54 R VDD VDD pm1p2_svt_lp W=340n L=60n m=1
MMP2 net67 net0144 net54 VDD pm1p2_svt_lp W=150n L=60n m=1
MMP1 net093 CKP net67 VDD pm1p2_svt_lp W=150n L=60n m=1
MMP3 net46 net33 net54 VDD pm1p2_svt_lp W=340n L=60n m=1
XXI29 net46 CKP CKN VDD VSS net33 / TSINV pl=6E-08 pw=1.5E-07 nl=6E-08 nw=1.5E-07
XXI30 D CKN CKP VDD VSS net33 / TSINV pl=6E-08 pw=2.8E-07 nl=6E-08 nw=2E-07
XI3 net0144 VDD VSS Q / INV pl=6E-08 pw=4E-07 nl=6E-08 nw=2.8E-07
XI6 RN VDD VSS R / INV pl=6E-08 pw=3.4E-07 nl=6E-08 nw=2.4E-07
XI7 net093 VDD VSS QN / INV pl=6E-08 pw=4E-07 nl=6E-08 nw=2.8E-07
XI5 CKN VDD VSS CKP / INV pl=6E-08 pw=3.4E-07 nl=6E-08 nw=2.4E-07
XI8 net093 VDD VSS net0144 / INV pl=6E-08 pw=3.4E-07 nl=6E-08 nw=2.4E-07
XXI4 CK VDD VSS CKN / INV pl=6E-08 pw=3.4E-07 nl=6E-08 nw=2.4E-07
XXI9 CKP CKN net46 net093 VDD VSS / TG pl=6E-08 pw=3.4E-07 nl=6E-08 nw=2.4E-07
.ENDS
