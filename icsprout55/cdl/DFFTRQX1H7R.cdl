.SUBCKT DFFTRQX1H7R CK D Q RN VDD VSS
*.PININFO CK:I D:I RN:I Q:O VDD:B VSS:B
XXI18 net32 net24 net034 net33 VDD VSS / TG pl=6E-08 pw=2.8E-07 nl=6E-08 nw=2.4E-07
XXI17 D RN VDD VSS net034 / NAND2 pl=6E-08 pw=2.8E-07 nl=6E-08 nw=2E-07
XXI14 net46 net24 net32 VDD VSS net33 / TSINV pl=6E-08 pw=1.5E-07 nl=6E-08 nw=1.5E-07
XXI9 net46 net24 net32 VDD VSS net25 / TSINV pl=6E-08 pw=3E-07 nl=6E-08 nw=2.2E-07
XXI15 net9 net32 net24 VDD VSS net25 / TSINV pl=6E-08 pw=1.5E-07 nl=6E-08 nw=1.5E-07
XXI7 net33 VDD VSS net46 / INV pl=6E-08 pw=3E-07 nl=6E-08 nw=2.2E-07
XXI13 net32 VDD VSS net24 / INV pl=6E-08 pw=2.8E-07 nl=6E-08 nw=2E-07
XXI12 net25 VDD VSS Q / INV pl=6E-08 pw=3.4E-07 nl=6E-08 nw=2.4E-07
XXI10 net25 VDD VSS net9 / INV pl=6E-08 pw=3E-07 nl=6E-08 nw=2.2E-07
XXI4 CK VDD VSS net32 / INV pl=6E-08 pw=2.8E-07 nl=6E-08 nw=2E-07
.ENDS
