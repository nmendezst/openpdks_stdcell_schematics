.SUBCKT DFFSQX1H7R CK D Q SN VDD VSS
*.PININFO CK:I D:I SN:I Q:O VDD:B VSS:B
MMN1 net0161 net32 net36 VSS nm1p2_svt_lp W=150n L=60n m=1
MMN2 net36 net048 VSS VSS nm1p2_svt_lp W=150n L=60n m=1
MMN5 net0161 net086 VSS VSS nm1p2_svt_lp W=150n L=60n m=1
MMN4 net087 net33 VSS VSS nm1p2_svt_lp W=190n L=60n m=1
MMP4 net54 net086 VDD VDD pm1p2_svt_lp W=150n L=60n m=1
MMP2 net058 net048 net54 VDD pm1p2_svt_lp W=150n L=60n m=1
MMP1 net0161 net24 net058 VDD pm1p2_svt_lp W=150n L=60n m=1
MMP3 net087 net33 net54 VDD pm1p2_svt_lp W=200n L=60n m=1
XXI29 net087 net24 net32 VDD VSS net33 / TSINV pl=6E-08 pw=1.5E-07 nl=6E-08 nw=1.5E-07
XXI30 net080 net32 net24 VDD VSS net33 / TSINV pl=6E-08 pw=2E-07 nl=6E-08 nw=2E-07
XXI37 D VDD VSS net080 / INV pl=6E-08 pw=2.7E-07 nl=6E-08 nw=2.1E-07
XXI12 net0161 VDD VSS Q / INV pl=6E-08 pw=2.7E-07 nl=6E-08 nw=2.1E-07
XXI31 SN VDD VSS net086 / INV pl=6E-08 pw=1.5E-07 nl=6E-08 nw=1.5E-07
XXI13 net32 VDD VSS net24 / INV pl=6E-08 pw=2.1E-07 nl=6E-08 nw=1.7E-07
XXI10 net0161 VDD VSS net048 / INV pl=6E-08 pw=1.9E-07 nl=6E-08 nw=1.5E-07
XXI4 CK VDD VSS net32 / INV pl=6E-08 pw=2.1E-07 nl=6E-08 nw=1.7E-07
XXI9 net24 net32 net087 net0161 VDD VSS / TG pl=6E-08 pw=1.9E-07 nl=6E-08 nw=1.5E-07
.ENDS
