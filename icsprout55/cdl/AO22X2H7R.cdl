.SUBCKT AO22X2H7R A0 A1 B0 B1 VDD VSS Y
*.PININFO A0:I A1:I B0:I B1:I Y:O VDD:B VSS:B
MMNM0 net42 B1 net30 VSS nm1p2_svt_lp W=150n L=60n m=1
MMNM1 net30 B0 VSS VSS nm1p2_svt_lp W=150n L=60n m=1
MMNM2 net42 A1 net31 VSS nm1p2_svt_lp W=150n L=60n m=1
MMNM3 net31 A0 VSS VSS nm1p2_svt_lp W=150n L=60n m=1
MMPM0 net35 A0 VDD VDD pm1p2_svt_lp W=190n L=60n m=1
MMPM1 net42 B0 net35 VDD pm1p2_svt_lp W=190n L=60n m=1
MMPM2 net35 A1 VDD VDD pm1p2_svt_lp W=190n L=60n m=1
MMPM3 net42 B1 net35 VDD pm1p2_svt_lp W=190n L=60n m=1
XXI1 net42 VDD VSS Y / INV pl=60n pw=380n nl=60n nw=300n
.ENDS
