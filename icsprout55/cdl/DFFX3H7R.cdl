.SUBCKT DFFX3H7R CK D Q QN VDD VSS
*.PININFO CK:I D:I Q:O QN:O VDD:B VSS:B
XI13 net46 CKP CKN VDD VSS net33 / TSINV pl=6E-08 pw=1.5E-07 nl=6E-08 nw=1.5E-07
XI12 D CKN CKP VDD VSS net33 / TSINV pl=60n pw=340n nl=60n nw=240n
XI11 net46 CKP CKN VDD VSS net25 / TSINV pl=60n pw=360n nl=60n nw=260n
XI10 net9 CKN CKP VDD VSS net25 / TSINV pl=6E-08 pw=1.5E-07 nl=6E-08 nw=1.5E-07
XI19 net33 VDD VSS net46 / INV pl=60n pw=360n nl=60n nw=260n
XI18 CKN VDD VSS CKP / INV pl=6E-08 pw=3.4E-07 nl=6E-08 nw=2.4E-07
XI17 net25 VDD VSS Q / INV pl=60n pw=600n nl=60n nw=420n
XI16 net25 VDD VSS net9 / INV pl=6E-08 pw=3.4E-07 nl=6E-08 nw=2.4E-07
XI15 net9 VDD VSS QN / INV pl=60n pw=600n nl=60n nw=420n
XI14 CK VDD VSS CKN / INV pl=6E-08 pw=3.4E-07 nl=6E-08 nw=2.4E-07
.ENDS
