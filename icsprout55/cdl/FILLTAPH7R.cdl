.SUBCKT FILLTAPH7R VDD VSS
*.PININFO VDD:I VSS:I
.ENDS
