.SUBCKT AO31X3H7R A0 A1 A2 B0 VDD VSS Y
*.PININFO A0:I A1:I A2:I B0:I Y:O VDD:B VSS:B
MMNM3 net1 B0 VSS VSS nm1p2_svt_lp W=200n L=60n m=1
MMNM2 net11 A0 VSS VSS nm1p2_svt_lp W=200n L=60n m=1
MMNM1 net10 A1 net11 VSS nm1p2_svt_lp W=200n L=60n m=1
MMNM0 net1 A2 net10 VSS nm1p2_svt_lp W=200n L=60n m=1
MMPM3 net1 B0 net13 VDD pm1p2_svt_lp W=250n L=60n m=1
MMPM2 net13 A2 VDD VDD pm1p2_svt_lp W=250n L=60n m=1
MMPM1 net13 A1 VDD VDD pm1p2_svt_lp W=250n L=60n m=1
MMPM0 net13 A0 VDD VDD pm1p2_svt_lp W=250n L=60n m=1
XXI3 net1 VDD VSS Y / INV pl=60n pw=570n nl=60n nw=450n
.ENDS
