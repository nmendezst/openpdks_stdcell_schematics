.SUBCKT AOI31X2H7R A0 A1 A2 B0 VDD VSS Y
*.PININFO A0:I A1:I A2:I B0:I Y:O VDD:B VSS:B
MMP3 net31 A1 VDD VDD pm1p2_svt_lp W=380n L=60n m=1
MMP2 Y B0 net31 VDD pm1p2_svt_lp W=380n L=60n m=1
MMP1 net31 A2 VDD VDD pm1p2_svt_lp W=380n L=60n m=1
MMP0 net31 A0 VDD VDD pm1p2_svt_lp W=380n L=60n m=1
MMN0 Y B0 VSS VSS nm1p2_svt_lp W=300n L=60n m=1
MMN1 Y A2 net36 VSS nm1p2_svt_lp W=300n L=60n m=1
MMN4 net36 A1 net35 VSS nm1p2_svt_lp W=300n L=60n m=1
MMN5 net35 A0 VSS VSS nm1p2_svt_lp W=300n L=60n m=1
.ENDS
