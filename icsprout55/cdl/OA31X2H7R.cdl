.SUBCKT OA31X2H7R A0 A1 A2 B0 VDD VSS Y
*.PININFO A0:I A1:I A2:I B0:I Y:O VDD:B VSS:B
MMNM3 net045 B0 net34 VSS nm1p2_svt_lp W=150n L=60n m=1
MMNM2 net34 A2 VSS VSS nm1p2_svt_lp W=150n L=60n m=1
MMNM1 net34 A1 VSS VSS nm1p2_svt_lp W=150n L=60n m=1
MMNM0 net34 A0 VSS VSS nm1p2_svt_lp W=150n L=60n m=1
MPM2 net17 A0 VDD VDD pm1p2_svt_lp W=190n L=60n m=1
MMPM3 net045 B0 VDD VDD pm1p2_svt_lp W=190n L=60n m=1
MPM1 net13 A1 net17 VDD pm1p2_svt_lp W=190n L=60n m=1
MPM0 net045 A2 net13 VDD pm1p2_svt_lp W=190n L=60n m=1
XXI3 net045 VDD VSS Y / INV pl=6e-08 pw=3.8e-07 nl=6e-08 nw=3e-07
.ENDS
