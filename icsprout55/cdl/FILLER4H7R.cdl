.SUBCKT FILLER4H7R VDD VSS
*.PININFO VDD:B VSS:B
.ENDS
