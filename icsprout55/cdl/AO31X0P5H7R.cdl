.SUBCKT AO31X0P5H7R A0 A1 A2 B0 VDD VSS Y
*.PININFO A0:I A1:I A2:I B0:I Y:O VDD:B VSS:B
MMNM3 net36 B0 VSS VSS nm1p2_svt_lp W=150n L=60n m=1
MMNM2 net28 A0 VSS VSS nm1p2_svt_lp W=150n L=60n m=1
MMNM1 net13 A1 net28 VSS nm1p2_svt_lp W=150n L=60n m=1
MMNM0 net36 A2 net13 VSS nm1p2_svt_lp W=150n L=60n m=1
MMPM3 net36 B0 net8 VDD pm1p2_svt_lp W=190n L=60n m=1
MMPM2 net8 A2 VDD VDD pm1p2_svt_lp W=190n L=60n m=1
MMPM1 net8 A1 VDD VDD pm1p2_svt_lp W=190n L=60n m=1
MMPM0 net8 A0 VDD VDD pm1p2_svt_lp W=190n L=60n m=1
XXI3 net36 VDD VSS Y / INV pl=60n pw=190n nl=60n nw=150n
.ENDS
