.SUBCKT AND2X1P4H7R A B VDD VSS Y
*.PININFO A:I B:I Y:O VDD:B VSS:B
MMN0 net26 B net6 VSS nm1p2_svt_lp W=150n L=60n m=1
MMN1 net6 A VSS VSS nm1p2_svt_lp W=150n L=60n m=1
MMP1 net26 B VDD VDD pm1p2_svt_lp W=190n L=60n m=1
MMP0 net26 A VDD VDD pm1p2_svt_lp W=190n L=60n m=1
XXI2 net26 VDD VSS Y / INV pl=6e-08 pw=3.14e-07 nl=6e-08 nw=2.46e-07
.ENDS
