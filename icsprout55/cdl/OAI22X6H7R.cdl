.SUBCKT OAI22X6H7R A0 A1 B0 B1 VDD VSS Y
*.PININFO A0:I A1:I B0:I B1:I Y:O VDD:B VSS:B
MNM3 net8 A0 VSS VSS nm1p2_svt_lp W=900n L=60n m=1
MNM4 net8 A1 VSS VSS nm1p2_svt_lp W=900n L=60n m=1
MNM5 Y B1 net8 VSS nm1p2_svt_lp W=900n L=60n m=1
MMN5 Y B0 net8 VSS nm1p2_svt_lp W=900n L=60n m=1
MPM4 Y B1 net049 VDD pm1p2_svt_lp W=1.14u L=60n m=1
MPM5 net049 B0 VDD VDD pm1p2_svt_lp W=1.14u L=60n m=1
MPM2 net046 A0 VDD VDD pm1p2_svt_lp W=1.14u L=60n m=1
MPM3 Y A1 net046 VDD pm1p2_svt_lp W=1.14u L=60n m=1
.ENDS
