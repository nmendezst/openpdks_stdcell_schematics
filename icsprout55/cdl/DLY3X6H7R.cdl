.SUBCKT DLY3X6H7R A VDD VSS Y
*.PININFO A:I Y:O VDD:B VSS:B
XI3 net013 VDD VSS Y / INV pl=60n pw=1.14u nl=60n nw=570n
XI2 net014 VDD VSS net013 / INV pl=180n pw=250n nl=180n nw=160n
XI1 net015 VDD VSS net014 / INV pl=180n pw=190n nl=180n nw=150n
XI0 A VDD VSS net015 / INV pl=60n pw=190n nl=60n nw=150n
.ENDS
