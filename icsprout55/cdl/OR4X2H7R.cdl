.SUBCKT OR4X2H7R A B C D VDD VSS Y
*.PININFO A:I B:I C:I D:I Y:O VDD:B VSS:B
MNM0 net22 B VSS VSS nm1p2_svt_lp W=150n L=60n m=1
MNM1 net22 C VSS VSS nm1p2_svt_lp W=150n L=60n m=1
MNM2 net22 D VSS VSS nm1p2_svt_lp W=150n L=60n m=1
MMNM0 net22 A VSS VSS nm1p2_svt_lp W=150n L=60n m=1
MMPM3 net22 D net21 VDD pm1p2_svt_lp W=190n L=60n m=1
MMPM2 net21 C net17 VDD pm1p2_svt_lp W=190n L=60n m=1
MMPM1 net17 B net13 VDD pm1p2_svt_lp W=190n L=60n m=1
MMPM0 net13 A VDD VDD pm1p2_svt_lp W=190n L=60n m=1
XXI4 net22 VDD VSS Y / INV pl=6e-08 pw=3.8e-07 nl=6e-08 nw=3e-07
.ENDS
