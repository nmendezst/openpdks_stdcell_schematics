.SUBCKT AO21X4H7R A0 A1 B0 VDD VSS Y
*.PININFO A0:I A1:I B0:I Y:O VDD:B VSS:B
MMNM0 net42 A1 net55 VSS nm1p2_svt_lp W=250n L=60n m=1
MMNM1 net55 A0 VSS VSS nm1p2_svt_lp W=250n L=60n m=1
MMNM2 net42 B0 VSS VSS nm1p2_svt_lp W=250n L=60n m=1
MMPM0 net52 A0 VDD VDD pm1p2_svt_lp W=310n L=60n m=1
MMPM1 net52 A1 VDD VDD pm1p2_svt_lp W=310n L=60n m=1
MMPM2 net42 B0 net52 VDD pm1p2_svt_lp W=310n L=60n m=1
XXI1 net42 VDD VSS Y / INV pl=60n pw=760n nl=60n nw=600n
.ENDS
