.SUBCKT AO22X6H7R A0 A1 B0 B1 VDD VSS Y
*.PININFO A0:I A1:I B0:I B1:I Y:O VDD:B VSS:B
MMNM3 net13 A0 VSS VSS nm1p2_svt_lp W=250n L=60n m=1
MMNM2 net1 A1 net13 VSS nm1p2_svt_lp W=250n L=60n m=1
MMNM1 net14 B0 VSS VSS nm1p2_svt_lp W=250n L=60n m=1
MMNM0 net1 B1 net14 VSS nm1p2_svt_lp W=250n L=60n m=1
MMPM3 net1 B1 net8 VDD pm1p2_svt_lp W=310n L=60n m=1
MMPM2 net8 A1 VDD VDD pm1p2_svt_lp W=310n L=60n m=1
MMPM1 net1 B0 net8 VDD pm1p2_svt_lp W=310n L=60n m=1
MMPM0 net8 A0 VDD VDD pm1p2_svt_lp W=310n L=60n m=1
XXI1 net1 VDD VSS Y / INV pl=60n pw=1.14u nl=60n nw=900n
.ENDS
