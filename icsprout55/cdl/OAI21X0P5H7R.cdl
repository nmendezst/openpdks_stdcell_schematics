.SUBCKT OAI21X0P5H7R A0 A1 B0 VDD VSS Y
*.PININFO A0:I A1:I B0:I Y:O VDD:B VSS:B
MNM1 net8 A1 VSS VSS nm1p2_svt_lp W=150n L=60n m=1
MMN5 Y B0 net8 VSS nm1p2_svt_lp W=150n L=60n m=1
MNM0 net8 A0 VSS VSS nm1p2_svt_lp W=150n L=60n m=1
MPM1 Y B0 VDD VDD pm1p2_svt_lp W=190n L=60n m=1
MMP3 net033 A0 VDD VDD pm1p2_svt_lp W=190n L=60n m=1
MPM0 Y A1 net033 VDD pm1p2_svt_lp W=190n L=60n m=1
.ENDS
