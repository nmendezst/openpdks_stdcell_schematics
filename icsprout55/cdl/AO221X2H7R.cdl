.SUBCKT AO221X2H7R A0 A1 B0 B1 C0 VDD VSS Y
*.PININFO A0:I A1:I B0:I B1:I C0:I Y:O VDD:B VSS:B
XXI3 net52 VDD VSS Y / INV pl=60n pw=380n nl=60n nw=300n
MMPM3 net42 B1 net38 VDD pm1p2_svt_lp W=190n L=60n m=1
MMPM4 net52 C0 net42 VDD pm1p2_svt_lp W=190n L=60n m=1
MMPM2 net42 B0 net38 VDD pm1p2_svt_lp W=190n L=60n m=1
MMPM1 net38 A1 VDD VDD pm1p2_svt_lp W=190n L=60n m=1
MMPM0 net38 A0 VDD VDD pm1p2_svt_lp W=190n L=60n m=1
MMNM0 net52 A1 net46 VSS nm1p2_svt_lp W=150n L=60n m=1
MMNM1 net46 A0 VSS VSS nm1p2_svt_lp W=150n L=60n m=1
MMNM4 net52 C0 VSS VSS nm1p2_svt_lp W=150n L=60n m=1
MMNM3 net47 B0 VSS VSS nm1p2_svt_lp W=150n L=60n m=1
MMNM2 net52 B1 net47 VSS nm1p2_svt_lp W=150n L=60n m=1
.ENDS
