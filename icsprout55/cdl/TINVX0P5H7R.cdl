.SUBCKT TINVX0P5H7R A OE VDD VSS Y
*.PININFO A:I OE:I Y:O VDD:B VSS:B
MMNM0 net15 A VSS VSS nm1p2_svt_lp W=150n L=60n m=1
MMN0 Y OE net15 VSS nm1p2_svt_lp W=150n L=60n m=1
MMPM1 Y OEN net024 VDD pm1p2_svt_lp W=190n L=60n m=1
MMPM0 net024 A VDD VDD pm1p2_svt_lp W=190n L=60n m=1
XXI3 OE VDD VSS OEN / INV pl=6E-08 pw=1.9e-07 nl=6E-08 nw=1.5e-07
.ENDS
