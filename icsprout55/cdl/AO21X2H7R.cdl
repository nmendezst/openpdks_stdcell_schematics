.SUBCKT AO21X2H7R A0 A1 B0 VDD VSS Y
*.PININFO A0:I A1:I B0:I Y:O VDD:B VSS:B
MMNM0 net8 A1 net23 VSS nm1p2_svt_lp W=150n L=60n m=1
MMNM1 net23 A0 VSS VSS nm1p2_svt_lp W=150n L=60n m=1
MMNM2 net8 B0 VSS VSS nm1p2_svt_lp W=150n L=60n m=1
MMPM0 net21 A0 VDD VDD pm1p2_svt_lp W=190n L=60n m=1
MMPM1 net21 A1 VDD VDD pm1p2_svt_lp W=190n L=60n m=1
MMPM2 net8 B0 net21 VDD pm1p2_svt_lp W=190n L=60n m=1
XXI1 net8 VDD VSS Y / INV pl=60n pw=380n nl=60n nw=300n
.ENDS
