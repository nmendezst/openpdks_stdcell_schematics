.SUBCKT LATHSRX0P5H7R D G Q QN RN SN VDD VSS
*.PININFO D:I G:I RN:I SN:I Q:O QN:O VDD:B VSS:B
MNM1 net47 D net44 VSS nm1p2_svt_lp W=200n L=60n m=1
MNM2 net41 netqn net44 VSS nm1p2_svt_lp W=150n L=60n m=1
MNM3 net0154 GN net41 VSS nm1p2_svt_lp W=150n L=60n m=1
MNM0 net0154 S VSS VSS nm1p2_svt_lp W=200n L=60n m=1
MNM4 net44 RN VSS VSS nm1p2_svt_lp W=200n L=60n m=1
MPM2 net052 netqn net058 VDD pm1p2_svt_lp W=150n L=60n m=1
MPM1 net0154 GP net052 VDD pm1p2_svt_lp W=150n L=60n m=1
MPM3 net47 D net058 VDD pm1p2_svt_lp W=280n L=60n m=1
MPM0 net0154 RN net058 VDD pm1p2_svt_lp W=200n L=60n m=1
MPM4 net058 S VDD VDD pm1p2_svt_lp W=280n L=60n m=1
XI3 G VDD VSS GN / INV pl=6E-08 pw=2.8E-07 nl=6E-08 nw=2E-07
XI0 GN VDD VSS GP / INV pl=6E-08 pw=2.8E-07 nl=6E-08 nw=2E-07
XI2 net0154 VDD VSS netqn / INV pl=6E-08 pw=2.8E-07 nl=6E-08 nw=2E-07
XI5 net0154 VDD VSS Q / INV pl=6E-08 pw=2.8E-07 nl=6E-08 nw=2E-07
XI4 netqn VDD VSS QN / INV pl=6E-08 pw=2.8E-07 nl=6E-08 nw=2E-07
XI1 SN VDD VSS S / INV pl=6E-08 pw=2.8E-07 nl=6E-08 nw=2E-07
XI7 GP GN net47 net0154 VDD VSS / TG pl=6E-08 pw=2.8E-07 nl=6E-08 nw=2E-07
.ENDS
