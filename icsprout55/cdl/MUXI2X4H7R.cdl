.SUBCKT MUXI2X4H7R A B S0 VDD VSS Y
*.PININFO A:I B:I S0:I Y:O VDD:B VSS:B
XXI8 S0 S0N net028 Y VDD VSS / TG pl=60n pw=640n nl=60n nw=570n
XXI7 S0N S0 net030 Y VDD VSS / TG pl=60n pw=640n nl=60n nw=570n
XXI0 S0 VDD VSS S0N / INV pl=60n pw=310n nl=60n nw=250n
XXI9 A VDD VSS net030 / INV pl=60n pw=760n nl=60n nw=600n
XXI10 B VDD VSS net028 / INV pl=60n pw=760n nl=60n nw=600n
.ENDS
